# Ansys Electronics Desktop project, version 2026.1

design TwinBuilder1 (Twin Builder)
components:
  shaft1 = shaft(omega0=4370 inertia=500)
  ramp1 = ramp(offset=1250 duration=30 amp=0)
  fueltank1 = fueltank(fuel_remain=0)
  const1 = const(const=0)
  const2 = const(const=0)
  MchRGnd1 = MchRGnd()
  damp_rot1 = damp_rot()
  inlet1 = inlet(gamma=1.4 p_amb0=101325 t_amb0=288.15 altitude=const2.val mach=const1.val)
  compressor1 = compressor(pressureratio=10.55 t_in=inlet1.t_out)
  combustor1 = combustor(eff=0.96 comb_ref=ramp1.val t_in=compressor1.t_out)
  turbine1 = turbine(eta_t=0.87 eta_m=0.9 temp_diff_comp=compressor1.temp_diff far_comb=combustor1.fa_ratio t_in=combustor1.t_out)
  nozzle1 = nozzle(area=0.01184 pressure_in=inlet1.p_out t_in=turbine1.t_out)
nets:
  net_1: compressor1.0, inlet1.0
  net_10: ramp1.val, combustor1.comb_ref
  net_11: turbine1.temp_diff_comp, compressor1.temp_diff
  net_12: fueltank1.0, combustor1.2
  net_13: turbine1.far_comb, combustor1.fa_ratio
  net_15: inlet1.altitude, const2.val
  net_16: inlet1.mach, const1.val
  net_18: shaft1.1, damp_rot1.0
  net_19: MchRGnd1.0, damp_rot1.1
  net_2: compressor1.t_in, inlet1.t_out
  net_20: shaft1.0, turbine1.2
  net_22: turbine1.t_in, combustor1.t_out
  net_3: inlet1.p_out, nozzle1.pressure_in
  net_4: combustor1.0, compressor1.1
  net_5: combustor1.t_in, compressor1.t_out
  net_6: turbine1.0, combustor1.1
  net_8: turbine1.1, nozzle1.0
  net_9: turbine1.t_out, nozzle1.t_in
setups:
  TR: TransientData(200s, 1ms, 0.05s, false, "")
reports:
  XY Plot9: turbine1.temp_diff_comp vs Time on TR : TR
  XY Plot10: inlet1.p_out vs Time on TR : TR
  XY Plot11: compressor1.power vs Time on TR : TR
  XY Plot14: compressor1.power vs Time on TR : TR
  XY Plot15: turbine1.power vs Time on TR : TR
  XY Plot16: turbine1.t_in vs Time on TR : TR
  XY Plot17: combustor1.t_out vs Time on TR : TR
  XY Plot18: turbine1.t_out vs Time on TR : TR
